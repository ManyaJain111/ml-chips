* parity8 vec 00000000 corner 0
.options gmin=1e-18 abstol=1e-18 reltol=1e-6 vntol=1e-9
.temp 5.795368642
.model  nmos  nmos  level = 54
+version = 4.0             binunit = 1               paramchk= 1               mobmod  = 0
+capmod  = 2               igcmod  = 1               igbmod  = 1               geomod  = 1
+diomod  = 1               rdsmod  = 0               rbodymod= 1               rgatemod= 0
+permod  = 1               acnqsmod= 0               trnqsmod= 0
+tnom    = 27              toxe    = 1.522279785e-09        toxp    = 1.3e-009        toxm    = 1.6e-009
+dtox    = 3e-010          epsrox  = 3.9             wint    = 5e-009          lint    = 0
+ll      = 0               wl      = 0               lln     = 1               wln     = 1
+lw      = 0               ww      = 0               lwn     = 1               wwn     = 1
+lwl     = 0               wwl     = 0               xpart   = 0               toxref  = 1.6e-009
+vth0    = 0.6528518816            k1      = 0.4             k2      = 0               k3      = 0
+k3b     = 0               w0      = 2.5e-006        dvt0    = 1               dvt1    = 2
+dvt2    = 0               dvt0w   = 0               dvt1w   = 0               dvt2w   = 0
+dsub    = 0.1             minv    = 0.05            voffl   = 0               dvtp0   = 1e-011
+dvtp1   = 0.1             lpe0    = 0               lpeb    = 0               xj      = 4.798787947e-08
+ngate   = 1e+023          ndep    = 3.986376013e+18       nsd     = 2e+020          phin    = 0
+cdsc    = 0               cdscb   = 0               cdscd   = 0               cit     = 0
+voff    = -0.1144         nfactor = 1.6             eta0    = 0.0115          etab    = 0
+vfb     = -0.55           u0      = 0.04370346366           ua      = 6e-010          ub      = 1.2e-018
+uc      = 0               vsat    = 155000          a0      = 1               ags     = 0
+a1      = 0               a2      = 1               b0      = 0               b1      = 0
+keta    = 0.04            dwg     = 0               dwb     = 0               pclm    = 0.02
+pdiblc1 = 0.001           pdiblc2 = 0.001           pdiblcb = -0.005          drout   = 0.5
+pvag    = 1e-020          delta   = 0.01            pscbe1  = 8.14e+008       pscbe2  = 1e-007
+fprout  = 0.2             pdits   = 0.01            pditsd  = 0.23            pditsl  = 2300000
+rsh     = 5               rdsw    = 190             rsw     = 75              rdw     = 75
+rdswmin = 0               rdwmin  = 0               rswmin  = 0               prwg    = 0
+prwb    = 0               wr      = 1               alpha0  = 0.074           alpha1  = 0.005
+beta0   = 30              agidl   = 0.0002          bgidl   = 2.1e+009        cgidl   = 0.0002
+egidl   = 0.8             aigbacc = 0.012           bigbacc = 0.0028          cigbacc = 0.002
+nigbacc = 1               aigbinv = 0.014           bigbinv = 0.004           cigbinv = 0.004
+eigbinv = 1.1             nigbinv = 3               aigc    = 0.015211        bigc    = 0.0027432
+cigc    = 0.002           aigsd   = 0.015211        bigsd   = 0.0027432       cigsd   = 0.002
+nigc    = 1               poxedge = 1               pigcd   = 1               ntox    = 1
+xrcrg1  = 12              xrcrg2  = 5
+cgso    = 8.5e-011        cgdo    = 8.5e-011        cgbo    = 2.56e-011       cgdl    = 2.653e-010
+cgsl    = 2.653e-010      ckappas = 0.03            ckappad = 0.03            acde    = 1
+moin    = 15              noff    = 0.9             voffcv  = 0.02
+kt1     = -0.11           kt1l    = 0               kt2     = 0.022           ute     = -1.5
+ua1     = 4.31e-009       ub1     = 7.61e-018       uc1     = -5.6e-011       prt     = 0
+at      = 33000
+fnoimod = 1               tnoimod = 0
+jss     = 0.0001          jsws    = 1e-011          jswgs   = 1e-010          njs     = 1
+ijthsfwd= 0.01            ijthsrev= 0.001           bvs     = 10              xjbvs   = 1
+jsd     = 0.0001          jswd    = 1e-011          jswgd   = 1e-010          njd     = 1
+ijthdfwd= 0.01            ijthdrev= 0.001           bvd     = 10              xjbvd   = 1
+pbs     = 1               cjs     = 0.0005          mjs     = 0.5             pbsws   = 1
+cjsws   = 5e-010          mjsws   = 0.33            pbswgs  = 1               cjswgs  = 3e-010
+mjswgs  = 0.33            pbd     = 1               cjd     = 0.0005          mjd     = 0.5
+pbswd   = 1               cjswd   = 5e-010          mjswd   = 0.33            pbswgd  = 1
+cjswgd  = 5e-010          mjswgd  = 0.33            tpb     = 0.005           tcj     = 0.001
+tpbsw   = 0.005           tcjsw   = 0.001           tpbswg  = 0.005           tcjswg  = 0.001
+xtis    = 3               xtid    = 3
+dmcg    = 0               dmci    = 0               dmdg    = 0               dmcgt   = 0
+dwj     = 0               xgw     = 0               xgl     = 0
+rshg    = 0.4             gbmin   = 1e-010          rbpb    = 5               rbpd    = 15
+rbps    = 15              rbdb    = 15              rbsb    = 15              ngcon   = 1
.model  pmos  pmos  level = 54
+version = 4.0             binunit = 1               paramchk= 1               mobmod  = 0
+capmod  = 2               igcmod  = 1               igbmod  = 1               geomod  = 1
+diomod  = 1               rdsmod  = 0               rbodymod= 1               rgatemod= 0
+permod  = 1               acnqsmod= 0               trnqsmod= 0
+tnom    = 27              toxe    = 1.734109152e-09       toxp    = 1.3e-009        toxm    = 1.62e-009
+dtox    = 3.2e-010        epsrox  = 3.9             wint    = 5e-009          lint    = 0
+ll      = 0               wl      = 0               lln     = 1               wln     = 1
+lw      = 0               ww      = 0               lwn     = 1               wwn     = 1
+lwl     = 0               wwl     = 0               xpart   = 0               toxref  = 1.6e-009
+vth0    = -0.5864023392         k1      = 0.4             k2      = -0.01           k3      = 0
+k3b     = 0               w0      = 2.5e-006        dvt0    = 1               dvt1    = 2
+dvt2    = -0.032          dvt0w   = 0               dvt1w   = 0               dvt2w   = 0
+dsub    = 0.1             minv    = 0.05            voffl   = 0               dvtp0   = 1e-011
+dvtp1   = 0.05            lpe0    = 0               lpeb    = 0               xj      = 1.03343923e-08
+ngate   = 1e+023          ndep    = 3.019749054e+18       nsd     = 2e+020          phin    = 0
+cdsc    = 0               cdscb   = 0               cdscd   = 0               cit     = 0
+voff    = -0.1            nfactor = 1.8             eta0    = 0.0115          etab    = 0
+vfb     = 0.55            u0      = 0.01493748398           ua      = 2e-009          ub      = 5e-019
+uc      = 0               vsat    = 135000          a0      = 1               ags     = 1e-020
+a1      = 0               a2      = 1               b0      = 0               b1      = 0
+keta    = -0.047          dwg     = 0               dwb     = 0               pclm    = 0.12
+pdiblc1 = 0.001           pdiblc2 = 0.001           pdiblcb = 3.4e-008        drout   = 0.56
+pvag    = 1e-020          delta   = 0.01            pscbe1  = 8.14e+008       pscbe2  = 9.58e-007
+fprout  = 0.2             pdits   = 0.08            pditsd  = 0.23            pditsl  = 2300000
+rsh     = 5               rdsw    = 240             rsw     = 75              rdw     = 75
+rdswmin = 0               rdwmin  = 0               rswmin  = 0               prwg    = 0
+prwb    = 0               wr      = 1               alpha0  = 0.074           alpha1  = 0.005
+beta0   = 30              agidl   = 0.0002          bgidl   = 2.1e+009        cgidl   = 0.0002
+egidl   = 0.8             aigbacc = 0.012           bigbacc = 0.0028          cigbacc = 0.002
+nigbacc = 1               aigbinv = 0.014           bigbinv = 0.004           cigbinv = 0.004
+eigbinv = 1.1             nigbinv = 3               aigc    = 0.0097          bigc    = 0.00125
+cigc    = 0.0008          aigsd   = 0.0097          bigsd   = 0.00125         cigsd   = 0.0008
+nigc    = 1               poxedge = 1               pigcd   = 1               ntox    = 1
+xrcrg1  = 12              xrcrg2  = 5
+cgso    = 8.5e-011        cgdo    = 8.5e-011        cgbo    = 2.56e-011       cgdl    = 2.653e-010
+cgsl    = 2.653e-010      ckappas = 0.03            ckappad = 0.03            acde    = 1
+moin    = 15              noff    = 0.9             voffcv  = 0.02
+kt1     = -0.11           kt1l    = 0               kt2     = 0.022           ute     = -1.5
+ua1     = 4.31e-009       ub1     = 7.61e-018       uc1     = -5.6e-011       prt     = 0
+at      = 33000
+fnoimod = 1               tnoimod = 0
+jss     = 0.0001          jsws    = 1e-011          jswgs   = 1e-010          njs     = 1
+ijthsfwd= 0.01            ijthsrev= 0.001           bvs     = 10              xjbvs   = 1
+jsd     = 0.0001          jswd    = 1e-011          jswgd   = 1e-010          njd     = 1
+ijthdfwd= 0.01            ijthdrev= 0.001           bvd     = 10              xjbvd   = 1
+pbs     = 1               cjs     = 0.0005          mjs     = 0.5             pbsws   = 1
+cjsws   = 5e-010          mjsws   = 0.33            pbswgs  = 1               cjswgs  = 3e-010
+mjswgs  = 0.33            pbd     = 1               cjd     = 0.0005          mjd     = 0.5
+pbswd   = 1               cjswd   = 5e-010          mjswd   = 0.33            pbswgd  = 1
+cjswgd  = 5e-010          mjswgd  = 0.33            tpb     = 0.005           tcj     = 0.001
+tpbsw   = 0.005           tcjsw   = 0.001           tpbswg  = 0.005           tcjswg  = 0.001
+xtis    = 3               xtid    = 3
+dmcg    = 0               dmci    = 0               dmdg    = 0               dmcgt   = 0
+dwj     = 0               xgw     = 0               xgl     = 0
+rshg    = 0.4             gbmin   = 1e-010          rbpb    = 5               rbpd    = 15
+rbps    = 15              rbdb    = 15              rbsb    = 15              ngcon   = 1
.subckt NAND2 a b out vdd gnd
MPA out a vdd vdd pmos W=1.28e-07 L=3.2e-08
MPB out b vdd vdd pmos W=1.28e-07 L=3.2e-08
MNA out a x gnd nmos W=6.4e-08 L=3.2e-08
MNB x b gnd gnd nmos W=6.4e-08 L=3.2e-08
.ends NAND2
Vvdd vdd 0 dc 0.8604096665
vd0 d0 0 dc 0
vd1 d1 0 dc 0
vd2 d2 0 dc 0
vd3 d3 0 dc 0
vd4 d4 0 dc 0
vd5 d5 0 dc 0
vd6 d6 0 dc 0
vd7 d7 0 dc 0
Xxr0_0_g1 d0 d1 xr0_0_n1 vdd 0 NAND2
Xxr0_0_g2 d0 xr0_0_n1 xr0_0_n2 vdd 0 NAND2
Xxr0_0_g3 d1 xr0_0_n1 xr0_0_n3 vdd 0 NAND2
Xxr0_0_g4 xr0_0_n2 xr0_0_n3 x0_0 vdd 0 NAND2
Xxr0_1_g1 d2 d3 xr0_1_n1 vdd 0 NAND2
Xxr0_1_g2 d2 xr0_1_n1 xr0_1_n2 vdd 0 NAND2
Xxr0_1_g3 d3 xr0_1_n1 xr0_1_n3 vdd 0 NAND2
Xxr0_1_g4 xr0_1_n2 xr0_1_n3 x0_1 vdd 0 NAND2
Xxr0_2_g1 d4 d5 xr0_2_n1 vdd 0 NAND2
Xxr0_2_g2 d4 xr0_2_n1 xr0_2_n2 vdd 0 NAND2
Xxr0_2_g3 d5 xr0_2_n1 xr0_2_n3 vdd 0 NAND2
Xxr0_2_g4 xr0_2_n2 xr0_2_n3 x0_2 vdd 0 NAND2
Xxr0_3_g1 d6 d7 xr0_3_n1 vdd 0 NAND2
Xxr0_3_g2 d6 xr0_3_n1 xr0_3_n2 vdd 0 NAND2
Xxr0_3_g3 d7 xr0_3_n1 xr0_3_n3 vdd 0 NAND2
Xxr0_3_g4 xr0_3_n2 xr0_3_n3 x0_3 vdd 0 NAND2
Xxr1_0_g1 x0_0 x0_1 xr1_0_n1 vdd 0 NAND2
Xxr1_0_g2 x0_0 xr1_0_n1 xr1_0_n2 vdd 0 NAND2
Xxr1_0_g3 x0_1 xr1_0_n1 xr1_0_n3 vdd 0 NAND2
Xxr1_0_g4 xr1_0_n2 xr1_0_n3 x1_0 vdd 0 NAND2
Xxr1_1_g1 x0_2 x0_3 xr1_1_n1 vdd 0 NAND2
Xxr1_1_g2 x0_2 xr1_1_n1 xr1_1_n2 vdd 0 NAND2
Xxr1_1_g3 x0_3 xr1_1_n1 xr1_1_n3 vdd 0 NAND2
Xxr1_1_g4 xr1_1_n2 xr1_1_n3 x1_1 vdd 0 NAND2
Xxr2_0_g1 x1_0 x1_1 xr2_0_n1 vdd 0 NAND2
Xxr2_0_g2 x1_0 xr2_0_n1 xr2_0_n2 vdd 0 NAND2
Xxr2_0_g3 x1_1 xr2_0_n1 xr2_0_n3 vdd 0 NAND2
Xxr2_0_g4 xr2_0_n2 xr2_0_n3 parity vdd 0 NAND2
.control
set numdgt=12
op
print i(vvdd) i(vd0) i(vd1) i(vd2) i(vd3) i(vd4) i(vd5) i(vd6)
print i(vd7) v(parity)
.endc
.end
